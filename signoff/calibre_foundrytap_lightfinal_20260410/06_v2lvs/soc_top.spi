.INCLUDE /ip/tsmc/tsmc16adfp/source/DAFP0203001_2_X/Executable_Package/Collaterals/Tech/LVS/N16ADFP_LVS_Calibre/source.added
.INCLUDE /ip/tsmc/tsmc16adfp/source/DAFP0203001_2_X/Executable_Package/Collaterals/IP/stdcell/N16ADFP_StdCell/SPICE/N16ADFP_StdCell_100b.spi
.INCLUDE /ip/tsmc/tsmc16adfp/source/DAFP0203001_2_X/Executable_Package/Collaterals/IP/sram/N16ADFP_SRAM/SPICE/N16ADFP_SRAM_100a.spi
.INCLUDE /home/fy2243/soc_design/signoff/calibre_foundrytap_lightfinal_20260410/06_v2lvs/soc_top_subckt.spi
