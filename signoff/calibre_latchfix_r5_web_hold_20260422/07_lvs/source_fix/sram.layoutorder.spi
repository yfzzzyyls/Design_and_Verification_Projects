.subckt TS1N16ADFPCLLLVTA512X45M4SWSHOD VDDM VDD Q[0] BWEB[0] D[0] Q[1] BWEB[1] D[1] Q[2] BWEB[2] D[2] Q[3] BWEB[3] D[3] Q[4] BWEB[4] D[4] Q[5] BWEB[5] D[5] Q[6] BWEB[6] D[6] Q[7] BWEB[7] D[7] Q[8] BWEB[8] D[8] Q[9] BWEB[9] D[9] Q[10] BWEB[10] D[10] Q[11] BWEB[11] D[11] Q[12] BWEB[12] D[12] Q[13] BWEB[13] D[13] Q[14] BWEB[14] D[14] Q[15] BWEB[15] D[15] Q[16] BWEB[16] D[16] Q[17] BWEB[17] D[17] Q[18] BWEB[18] D[18] Q[19] BWEB[19] D[19] Q[20] BWEB[20] D[20] Q[21] BWEB[21] D[21] Q[22] BWEB[22] D[22] A[1] A[0] A[8] CEB DSLP SLP WTSEL[0] WEB WTSEL[1] CLK A[5] A[6] SD A[7] A[4] A[3] A[2] RTSEL[0] RTSEL[1] PUDELAY Q[23] BWEB[23] D[23] Q[24] BWEB[24] D[24] Q[25] BWEB[25] D[25] Q[26] BWEB[26] D[26] Q[27] BWEB[27] D[27] Q[28] BWEB[28] D[28] Q[29] BWEB[29] D[29] Q[30] BWEB[30] D[30] Q[31] BWEB[31] D[31] Q[32] BWEB[32] D[32] Q[33] BWEB[33] D[33] Q[34] BWEB[34] D[34] Q[35] BWEB[35] D[35] Q[36] BWEB[36] D[36] Q[37] BWEB[37] D[37] Q[38] BWEB[38] D[38] Q[39] BWEB[39] D[39] Q[40] BWEB[40] D[40] Q[41] BWEB[41] D[41] Q[42] BWEB[42] D[42] Q[43] BWEB[43] D[43] Q[44] BWEB[44] D[44] VSS
.ends
